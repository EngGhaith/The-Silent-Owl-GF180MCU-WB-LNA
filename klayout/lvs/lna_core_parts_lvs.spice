.SUBCKT lna_core_parts vdd vss vbias_cg vbias_cs vbias_cas rf_out_pad rf_in_pad g_cg
x1 net3 rf_out_pad vss lna_core_output_match
x2 vss net1 rf_in_pad lna_core_input_match
x3 vbias_cs vdd vss vbias_cg net2 g_cg net1 lna_core_cg
x4 net3 vbias_cas net2 vdd vss lna_core_cs
CDCPL0 vdd vss cap_mim_2f0fF W=5.1u L=6.3u M=280
.ENDS
.SUBCKT lna_core_output_match output_cs rf_out_pad vss
C1 output_cs rf_out_pad cap_mim_2f0fF W=64.61u L=54.0u
.ENDS
.SUBCKT lna_core_input_match vss input_cg rf_in_pad
C15 rf_in_pad input_cg cap_mim_2f0fF W=24.82u L=24.82u
.ENDS
.SUBCKT lna_core_cg vbias_cs vdd vss vbias_cg output_cs g_cg input_match
MM1 vm2 g_cg input_match vss nfet_05v0 L=0.6u W=40u nf=10 ad='int((nf+1)/2) * W/nf * 0.18u' as='int((nf+2)/2) * W/nf * 0.18u' pd='2*int((nf+1)/2) * (W/nf + 0.18u)' ps='2*int((nf+2)/2) * (W/nf + 0.18u)' nrd='0.18u / W' nrs='0.18u / W' sa=0 sb=0 sd=0 m=14
RR3 vbias_cg g_cg vss ppolyf_u_1k W=1u L=48.35u
C2 output_cs vm2 cap_mim_2f0fF W=58.22u L=58.22u
C3 vss g_cg cap_mim_2f0fF W=49.89u L=49.89u m=4
MM3 input_match vss input_match vss nfet_05v0 L=0.6u W=8u nf=2 ad='int((nf+1)/2) * W/nf * 0.18u' as='int((nf+2)/2) * W/nf * 0.18u' pd='2*int((nf+1)/2) * (W/nf + 0.18u)' ps='2*int((nf+2)/2) * (W/nf + 0.18u)' nrd='0.18u / W' nrs='0.18u / W' sa=0 sb=0 sd=0 m=4
RR4 vbias_cs output_cs vss ppolyf_u_1k W=1u L=48.35u
.ENDS
.SUBCKT lna_core_cs output_match vbias_cas input_cg vdd vss
MM4D vm1 vss vm1 vss nfet_05v0 L=0.6u W=7u nf=2 ad='int((nf+1)/2) * W/nf * 0.18u' as='int((nf+2)/2) * W/nf * 0.18u' pd='2*int((nf+1)/2) * (W/nf + 0.18u)' ps='2*int((nf+2)/2) * (W/nf + 0.18u)' nrd='0.18u / W' nrs='0.18u / W' sa=0 sb=0 sd=0 m=2
MM2 output_match vbias_cas vm1 vss nfet_05v0 L=0.6u W=35u nf=10 ad='int((nf+1)/2) * W/nf * 0.18u' as='int((nf+2)/2) * W/nf * 0.18u' pd='2*int((nf+1)/2) * (W/nf + 0.18u)' ps='2*int((nf+2)/2) * (W/nf + 0.18u)' nrd='0.18u / W' nrs='0.18u / W' sa=0 sb=0 sd=0 m=4
MM3 vm1 input_cg vss vss nfet_03v3 L=0.28u W=20u nf=10 ad='int((nf+1)/2) * W/nf * 0.18u' as='int((nf+2)/2) * W/nf * 0.18u' pd='2*int((nf+1)/2) * (W/nf + 0.18u)' ps='2*int((nf+2)/2) * (W/nf + 0.18u)' nrd='0.18u / W' nrs='0.18u / W' sa=0 sb=0 sd=0 m=10
MM5 vss vss vss vss nfet_03v3 L=0.28u W=4u nf=2 ad='int((nf+1)/2) * W/nf * 0.18u' as='int((nf+2)/2) * W/nf * 0.18u' pd='2*int((nf+1)/2) * (W/nf + 0.18u)' ps='2*int((nf+2)/2) * (W/nf + 0.18u)' nrd='0.18u / W' nrs='0.18u / W' sa=0 sb=0 sd=0 m=2
.ENDS
