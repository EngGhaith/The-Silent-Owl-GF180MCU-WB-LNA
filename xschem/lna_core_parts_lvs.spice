* netgen reference for lna_core_parts (generated by mkref.py from the xschem netlist)
.subckt lna_core_parts vdd vss vbias_cg vbias_cs vbias_cas rf_out_pad rf_in_pad deemb_o deemb_s deemb_r deemb_2r deemb_0p5r open_dummy_lvs
x1 output_cs rf_out_pad vss lna_core_output_match
x2 vss net1 rf_in_pad lna_core_input_match
x3 vbias_cs vdd vss vbias_cg net2 net1 lna_core_cg
x4 output_cs vbias_cas net2 vdd vss lna_core_cs
x5 vss deemb_o open_dummy_lvs deemb_o
x6 vss deemb_s deemb_s
x7 vss deemb_r deemb_r
x8 vss deemb_2r deemb_2r
x9 vss deemb_0p5r deemb_0p5r
.ends
.subckt leq_model p1 p2
XR1 p1 p2 tm11k r_width=10u r_length=1u
.ends leq_model
.subckt l1_model p1 p2
XR1 p1 p2 tm11k r_width=13u r_length=1u
.ends l1_model
.subckt lshunt_out_model p1 p2
XR1 p1 p2 tm11k r_width=10u r_length=1u
.ends lshunt_out_model
.subckt ld2_model p1 p2
XR1 p1 p2 rm4 r_width=7u r_length=1u
.ends ld2_model
.subckt ld4_model p1 p2
XR1 p1 p2 tm11k r_width=6u r_length=1u
XR2 p1 p2 rm4 r_width=6u r_length=1u
XR3 p1 p2 rm3 r_width=6u r_length=1u
XR4 p1 p2 rm2 r_width=6u r_length=1u
.ends ld4_model
.subckt lna_core_output_match output_cs rf_out_pad vss
XXLSHUNT_OUT rf_out_pad vss lshunt_out_model
XC1 output_cs rf_out_pad cap_mim_2f0_m4m5_noshield c_width=64.61u c_length=54u
.ends
.subckt lna_core_input_match vss input_cg rf_in_pad
XXLEQ rf_in_pad vss leq_model
XC15 input_cg rf_in_pad cap_mim_2f0_m4m5_noshield c_width=24.82u c_length=24.82u
.ends
.subckt lna_core_cg vbias_cs vdd vss vbias_cg output_cs input_match
XM1 vm2 net1 input_match vss nfet_06v0 L=0.6u W=40u nf=10 m=14
XM3 input_match vss input_match vss nfet_06v0 L=0.6u W=8u nf=2 m=4
XXLD4 vdd vm2 ld4_model
XXL1 input_match vss l1_model
XC3 vss net1 cap_mim_2f0_m4m5_noshield c_width=49.89u c_length=49.89u m=4
XC2 vm2 output_cs cap_mim_2f0_m4m5_noshield c_width=58.22u c_length=58.22u
XR3 vbias_cg net1 vss ppolyf_u_1k_6p0 r_width=1u r_length=48.35u
XR4 vbias_cs output_cs vss ppolyf_u_1k_6p0 r_width=1u r_length=48.35u
.ends
.subckt lna_core_cs output_match vbias_cas input_cg vdd vss
XM4D vm1 vss vm1 vss nfet_06v0 L=0.6u W=7u nf=2 m=2
XM2 output_match vbias_cas vm1 vss nfet_06v0 L=0.6u W=35u nf=10 m=4
XM3 vm1 input_cg vss vss nfet_03v3 L=0.28u W=20u nf=10 m=10
XM5 vss vss vss vss nfet_03v3 L=0.28u W=4u nf=2 m=2
XXLD2 vdd output_match ld2_model
XC_CAS vss vbias_cas cap_mim_2f0_m4m5_noshield c_width=49.89u c_length=49.89u m=4
.ends
.subckt deemb_o G deemb_o open_dummy_lvs
XR1 open_dummy_lvs deemb_o rm3 r_width=1.62u r_length=1u
.ends
.subckt deemb_s G deemb_s
XR1 G deemb_s rm3 r_width=1.62u r_length=1u
.ends
.subckt deemb_r G deemb_r
XR1 net1 G G ppolyf_u_1k_6p0 r_width=1u r_length=3.72u m=5
XR2 G net1 G ppolyf_u_1k_6p0 r_width=1u r_length=3.72u m=5
XR3 net1 G G ppolyf_u_1k_6p0 r_width=1u r_length=3.72u m=5
XR4 G net1 G ppolyf_u_1k_6p0 r_width=1u r_length=3.72u m=5
XR5 G G G ppolyf_u_1k_6p0 r_width=1u r_length=3.72u m=5
XR6 G G G ppolyf_u_1k_6p0 r_width=1u r_length=3.72u m=5
XR7 G G G ppolyf_u_1k_6p0 r_width=1u r_length=3.72u m=5
XR8 G G G ppolyf_u_1k_6p0 r_width=1u r_length=3.72u m=5
XR9 net1 G G ppolyf_u_1k_6p0 r_width=1u r_length=3.72u m=5
XR10 G net1 G ppolyf_u_1k_6p0 r_width=1u r_length=3.72u m=5
XR11 net1 G G ppolyf_u_1k_6p0 r_width=1u r_length=3.72u m=5
XR12 G net1 G ppolyf_u_1k_6p0 r_width=1u r_length=3.72u m=5
XR13 G G G ppolyf_u_1k_6p0 r_width=1u r_length=3.72u m=5
XR14 G G G ppolyf_u_1k_6p0 r_width=1u r_length=3.72u m=5
XR15 G G G ppolyf_u_1k_6p0 r_width=1u r_length=3.72u m=5
XR16 G G G ppolyf_u_1k_6p0 r_width=1u r_length=3.72u m=5
XR17 G G G ppolyf_u_1k_6p0 r_width=1u r_length=3.72u m=5
XR18 G G G ppolyf_u_1k_6p0 r_width=1u r_length=3.72u m=5
XR19 G G G ppolyf_u_1k_6p0 r_width=1u r_length=3.72u m=5
XR20 G G G ppolyf_u_1k_6p0 r_width=1u r_length=3.72u m=5
XR21 net1 G G ppolyf_u_1k_6p0 r_width=1u r_length=3.72u m=5
XR22 G net1 G ppolyf_u_1k_6p0 r_width=1u r_length=3.72u m=5
XR23 net1 G G ppolyf_u_1k_6p0 r_width=1u r_length=3.72u m=5
XR24 G net1 G ppolyf_u_1k_6p0 r_width=1u r_length=3.72u m=5
XR25 G G G ppolyf_u_1k_6p0 r_width=1u r_length=3.72u m=5
XR26 G G G ppolyf_u_1k_6p0 r_width=1u r_length=3.72u m=5
XR27 G G G ppolyf_u_1k_6p0 r_width=1u r_length=3.72u m=5
XR28 G G G ppolyf_u_1k_6p0 r_width=1u r_length=3.72u m=5
XR29 net1 G G ppolyf_u_1k_6p0 r_width=1u r_length=3.72u m=5
XR30 G net1 G ppolyf_u_1k_6p0 r_width=1u r_length=3.72u m=5
XR31 net1 G G ppolyf_u_1k_6p0 r_width=1u r_length=3.72u m=5
XR32 G net1 G ppolyf_u_1k_6p0 r_width=1u r_length=3.72u m=5
XRM3 deemb_r net1 rm3 r_width=1.62u r_length=1u
.ends
.subckt deemb_2r G deemb_2r
XR1 G G G ppolyf_u_1k_6p0 r_width=1u r_length=3.72u m=5
XR2 G G G ppolyf_u_1k_6p0 r_width=1u r_length=3.72u m=5
XR3 G G G ppolyf_u_1k_6p0 r_width=1u r_length=3.72u m=5
XR4 G G G ppolyf_u_1k_6p0 r_width=1u r_length=3.72u m=5
XR5 G G G ppolyf_u_1k_6p0 r_width=1u r_length=3.72u m=5
XR6 G G G ppolyf_u_1k_6p0 r_width=1u r_length=3.72u m=5
XR7 G G G ppolyf_u_1k_6p0 r_width=1u r_length=3.72u m=5
XR8 G G G ppolyf_u_1k_6p0 r_width=1u r_length=3.72u m=5
XR9 net1 G G ppolyf_u_1k_6p0 r_width=1u r_length=3.72u m=5
XR10 G net1 G ppolyf_u_1k_6p0 r_width=1u r_length=3.72u m=5
XR11 net1 G G ppolyf_u_1k_6p0 r_width=1u r_length=3.72u m=5
XR12 G net1 G ppolyf_u_1k_6p0 r_width=1u r_length=3.72u m=5
XR13 G G G ppolyf_u_1k_6p0 r_width=1u r_length=3.72u m=5
XR14 G G G ppolyf_u_1k_6p0 r_width=1u r_length=3.72u m=5
XR15 G G G ppolyf_u_1k_6p0 r_width=1u r_length=3.72u m=5
XR16 G G G ppolyf_u_1k_6p0 r_width=1u r_length=3.72u m=5
XR17 G G G ppolyf_u_1k_6p0 r_width=1u r_length=3.72u m=5
XR18 G G G ppolyf_u_1k_6p0 r_width=1u r_length=3.72u m=5
XR19 G G G ppolyf_u_1k_6p0 r_width=1u r_length=3.72u m=5
XR20 G G G ppolyf_u_1k_6p0 r_width=1u r_length=3.72u m=5
XR21 G G G ppolyf_u_1k_6p0 r_width=1u r_length=3.72u m=5
XR22 G G G ppolyf_u_1k_6p0 r_width=1u r_length=3.72u m=5
XR23 G G G ppolyf_u_1k_6p0 r_width=1u r_length=3.72u m=5
XR24 G G G ppolyf_u_1k_6p0 r_width=1u r_length=3.72u m=5
XR25 G G G ppolyf_u_1k_6p0 r_width=1u r_length=3.72u m=5
XR26 G G G ppolyf_u_1k_6p0 r_width=1u r_length=3.72u m=5
XR27 G G G ppolyf_u_1k_6p0 r_width=1u r_length=3.72u m=5
XR28 G G G ppolyf_u_1k_6p0 r_width=1u r_length=3.72u m=5
XR29 net1 G G ppolyf_u_1k_6p0 r_width=1u r_length=3.72u m=5
XR30 G net1 G ppolyf_u_1k_6p0 r_width=1u r_length=3.72u m=5
XR31 net1 G G ppolyf_u_1k_6p0 r_width=1u r_length=3.72u m=5
XR32 G net1 G ppolyf_u_1k_6p0 r_width=1u r_length=3.72u m=5
XRM3 deemb_2r net1 rm3 r_width=1.62u r_length=1u
.ends
.subckt deemb_0p5r G deemb_0p5r
XR1 net1 G G ppolyf_u_1k_6p0 r_width=1u r_length=3.72u m=5
XR2 G net1 G ppolyf_u_1k_6p0 r_width=1u r_length=3.72u m=5
XR3 net1 G G ppolyf_u_1k_6p0 r_width=1u r_length=3.72u m=5
XR4 G net1 G ppolyf_u_1k_6p0 r_width=1u r_length=3.72u m=5
XR5 net1 G G ppolyf_u_1k_6p0 r_width=1u r_length=3.72u m=5
XR6 G net1 G ppolyf_u_1k_6p0 r_width=1u r_length=3.72u m=5
XR7 net1 G G ppolyf_u_1k_6p0 r_width=1u r_length=3.72u m=5
XR8 G net1 G ppolyf_u_1k_6p0 r_width=1u r_length=3.72u m=5
XR9 net1 G G ppolyf_u_1k_6p0 r_width=1u r_length=3.72u m=5
XR10 G net1 G ppolyf_u_1k_6p0 r_width=1u r_length=3.72u m=5
XR11 net1 G G ppolyf_u_1k_6p0 r_width=1u r_length=3.72u m=5
XR12 G net1 G ppolyf_u_1k_6p0 r_width=1u r_length=3.72u m=5
XR13 net1 G G ppolyf_u_1k_6p0 r_width=1u r_length=3.72u m=5
XR14 G net1 G ppolyf_u_1k_6p0 r_width=1u r_length=3.72u m=5
XR15 net1 G G ppolyf_u_1k_6p0 r_width=1u r_length=3.72u m=5
XR16 G net1 G ppolyf_u_1k_6p0 r_width=1u r_length=3.72u m=5
XR17 net1 G G ppolyf_u_1k_6p0 r_width=1u r_length=3.72u m=5
XR18 G net1 G ppolyf_u_1k_6p0 r_width=1u r_length=3.72u m=5
XR19 net1 G G ppolyf_u_1k_6p0 r_width=1u r_length=3.72u m=5
XR20 G net1 G ppolyf_u_1k_6p0 r_width=1u r_length=3.72u m=5
XR21 net1 G G ppolyf_u_1k_6p0 r_width=1u r_length=3.72u m=5
XR22 G net1 G ppolyf_u_1k_6p0 r_width=1u r_length=3.72u m=5
XR23 net1 G G ppolyf_u_1k_6p0 r_width=1u r_length=3.72u m=5
XR24 G net1 G ppolyf_u_1k_6p0 r_width=1u r_length=3.72u m=5
XR25 net1 G G ppolyf_u_1k_6p0 r_width=1u r_length=3.72u m=5
XR26 G net1 G ppolyf_u_1k_6p0 r_width=1u r_length=3.72u m=5
XR27 net1 G G ppolyf_u_1k_6p0 r_width=1u r_length=3.72u m=5
XR28 G net1 G ppolyf_u_1k_6p0 r_width=1u r_length=3.72u m=5
XR29 net1 G G ppolyf_u_1k_6p0 r_width=1u r_length=3.72u m=5
XR30 G net1 G ppolyf_u_1k_6p0 r_width=1u r_length=3.72u m=5
XR31 net1 G G ppolyf_u_1k_6p0 r_width=1u r_length=3.72u m=5
XR32 G net1 G ppolyf_u_1k_6p0 r_width=1u r_length=3.72u m=5
XRM3 deemb_0p5r net1 rm3 r_width=1.62u r_length=1u
.ends
