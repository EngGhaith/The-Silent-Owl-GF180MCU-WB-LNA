* netgen reference for lna_core_parts (generated by mkref.py from the xschem netlist)
.subckt lna_core_parts vdd vss vbias_cg vbias_cs vbias_cas rf_out_pad rf_in_pad
x1 net3 rf_out_pad lna_core_output_match
x2 vss net1 rf_in_pad lna_core_input_match
x3 vbias_cs vdd vss vbias_cg net2 net1 lna_core_cg
x4 net3 vbias_cas net2 vdd vss lna_core_cs
.ends
.subckt leq_main_model p1 p2
XR1 p1 p2 tm11k r_width=10u r_length=1u
.ends leq_main_model
.subckt l1_model p1 p2
XR1 p1 p2 tm11k r_width=13u r_length=1u
.ends l1_model
.subckt ld2_model p1 p2
XR1 p1 p2 rm4 r_width=7u r_length=1u
.ends ld2_model
.subckt ld4_model p1 p2
XR1 p1 p2 tm11k r_width=6u r_length=1u
XR2 p1 p2 rm4 r_width=6u r_length=1u
XR3 p1 p2 rm3 r_width=6u r_length=1u
XR4 p1 p2 rm2 r_width=6u r_length=1u
.ends ld4_model
.subckt lna_core_output_match output_cs rf_out_pad
XC11 output_cs rf_out_pad cap_mim_2f0_m4m5_noshield c_width=28u c_length=28u
.ends
.subckt lna_core_input_match vss input_cg rf_in_pad
XXLEQ rf_in_pad vss leq_main_model
XC15 input_cg rf_in_pad cap_mim_2f0_m4m5_noshield c_width=34.71u c_length=34.71u
XCPI input_cg vss cap_mim_2f0_m4m5_noshield c_width=26.71u c_length=26.71u
.ends
.subckt lna_core_cg vbias_cs vdd vss vbias_cg output_cs input_match
XM2 vm2 net1 input_match vss nfet_06v0 L=0.6u W=40u nf=10 m=14
XR1 vbias_cg net1 vss ppolyf_u_1k_6p0 r_width=1u r_length=48.35u
XC9 vss net1 cap_mim_2f0_m4m5_noshield c_width=49.89u c_length=49.89u m=4
XXL1 input_match vss l1_model
XM2D input_match vss input_match vss nfet_06v0 L=0.6u W=8u nf=2 m=4
XXLD4 vdd vm2 ld4_model
XR2 vbias_cs output_cs vss ppolyf_u_1k_6p0 r_width=1u r_length=48.35u
XC1 vm2 output_cs cap_mim_2f0_m4m5_noshield c_width=58.22u c_length=58.22u
.ends
.subckt lna_core_cs output_match vbias_cas input_cg vdd vss
XM4 output_match vbias_cas vm1 vss nfet_06v0 L=0.6u W=35u nf=10 m=4
XM1 vm1 input_cg vss vss nfet_03v3 L=0.28u W=20u nf=10 m=10
XXLD2 vdd output_match ld2_model
XM1D vss vss vss vss nfet_03v3 L=0.28u W=4u nf=2 m=2
XC1 vss vbias_cas cap_mim_2f0_m4m5_noshield c_width=49.89u c_length=49.89u m=4
XM4D vm1 vss vm1 vss nfet_06v0 L=0.6u W=7u nf=2 m=2
.ends
