* SPICE3 file created from gf180mcu_fd_io__asig_5p0.ext - technology: gf180mcuD

.option scale=5n

*.SUBCKT gf180mcu_fd_io__asig_5p0 DVDD ASIG5V DVSS VDD VSS
.SUBCKT gf180mcu_fd_io__asig_5p0 DVDD ASIG5V DVSS VDD VSS
D0 DVSS ASIG5V diode_nd2ps_06v0 pj=21200 area=6e+06
D1 DVSS ASIG5V diode_nd2ps_06v0 pj=21200 area=6e+06
D2 ASIG5V DVDD diode_pd2nw_06v0 pj=21200 area=6e+06
D3 DVSS ASIG5V diode_nd2ps_06v0 pj=21200 area=6e+06
D4 DVSS ASIG5V diode_nd2ps_06v0 pj=21200 area=6e+06
D5 ASIG5V DVDD diode_pd2nw_06v0 pj=21200 area=6e+06
D6 ASIG5V DVDD diode_pd2nw_06v0 pj=21200 area=6e+06
D7 ASIG5V DVDD diode_pd2nw_06v0 pj=21200 area=6e+06
X0 DVDD DVSS cap_nmos_06v0 c_width=3000 c_length=3000
X1 DVDD DVSS cap_nmos_06v0 c_width=3000 c_length=3000
X2 DVDD DVSS cap_nmos_06v0 c_width=3000 c_length=3000
X3 DVDD DVSS cap_nmos_06v0 c_width=3000 c_length=3000
X4 DVDD DVSS cap_nmos_06v0 c_width=3000 c_length=3000
X5 DVDD DVSS cap_nmos_06v0 c_width=3000 c_length=3000
X6 DVDD DVSS cap_nmos_06v0 c_width=3000 c_length=3000
X7 DVDD DVSS cap_nmos_06v0 c_width=3000 c_length=3000
X8 DVDD DVSS cap_nmos_06v0 c_width=3000 c_length=3000
X9 DVDD DVSS cap_nmos_06v0 c_width=3000 c_length=3000
X10 DVDD DVSS cap_nmos_06v0 c_width=3000 c_length=3000
X11 DVDD DVSS cap_nmos_06v0 c_width=3000 c_length=3000
X12 DVDD DVSS cap_nmos_06v0 c_width=3000 c_length=3000
X13 DVDD DVSS cap_nmos_06v0 c_width=3000 c_length=3000
X14 DVDD DVSS cap_nmos_06v0 c_width=3000 c_length=3000
X15 DVDD DVSS cap_nmos_06v0 c_width=3000 c_length=3000
X16 DVDD DVSS cap_nmos_06v0 c_width=3000 c_length=3000
X17 DVDD DVSS cap_nmos_06v0 c_width=3000 c_length=3000
X18 DVDD DVSS cap_nmos_06v0 c_width=3000 c_length=3000
X19 DVDD DVSS cap_nmos_06v0 c_width=3000 c_length=3000
X20 DVDD DVSS cap_nmos_06v0 c_width=3000 c_length=3000
X21 DVDD DVSS cap_nmos_06v0 c_width=3000 c_length=3000
X22 DVDD DVSS cap_nmos_06v0 c_width=3000 c_length=3000
X23 DVDD DVSS cap_nmos_06v0 c_width=3000 c_length=3000
X24 DVDD DVSS cap_nmos_06v0 c_width=3000 c_length=3000
X25 DVDD DVSS cap_nmos_06v0 c_width=3000 c_length=3000
X26 DVDD DVSS cap_nmos_06v0 c_width=3000 c_length=3000
X27 DVDD DVSS cap_nmos_06v0 c_width=3000 c_length=3000
X28 DVDD DVSS cap_nmos_06v0 c_width=3000 c_length=3000
X29 DVDD DVSS cap_nmos_06v0 c_width=3000 c_length=3000
D8 DVSS DVDD diode_nd2ps_06v0 pj=16400 area=1.6e+06
X30 DVDD DVSS cap_nmos_06v0 c_width=3000 c_length=3000
X31 DVDD DVSS cap_nmos_06v0 c_width=3000 c_length=3000
X32 DVDD DVSS cap_nmos_06v0 c_width=3000 c_length=3000
D9 DVSS DVDD diode_nd2ps_06v0 pj=16400 area=1.6e+06
X33 DVDD DVSS cap_nmos_06v0 c_width=3000 c_length=3000
D10 DVSS DVDD diode_nd2ps_06v0 pj=16400 area=1.6e+06
X34 DVDD DVSS cap_nmos_06v0 c_width=3000 c_length=3000
X35 DVDD DVSS cap_nmos_06v0 c_width=3000 c_length=3000
D11 DVSS DVDD diode_nd2ps_06v0 pj=16400 area=1.6e+06
C0 VDD DVDD 48.08535f
C1 VDD ASIG5V 21.91101f
C2 DVDD ASIG5V 0.62445p
C3 VDD DVSS 50.97537f
C4 DVDD DVSS 1.55036p
C5 DVSS ASIG5V 0.47973p
C6 VDD GF_NI_ASIG_5P0_BASE_0/comp018green_esd_hbm_0/VSUBS 47.06129f
C7 ASIG5V GF_NI_ASIG_5P0_BASE_0/comp018green_esd_hbm_0/VSUBS 0.27637p
C8 DVSS GF_NI_ASIG_5P0_BASE_0/comp018green_esd_hbm_0/VSUBS 0.20258p
C9 DVDD GF_NI_ASIG_5P0_BASE_0/comp018green_esd_hbm_0/VSUBS 0.35736p

.ENDS
