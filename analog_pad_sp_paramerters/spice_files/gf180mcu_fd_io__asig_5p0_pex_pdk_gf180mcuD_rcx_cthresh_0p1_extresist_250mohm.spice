* -----------------------------------------------------------------------------
* Magic PEX Netlist
* Generated by   : magic_pex_gf180_v7.py
* Date           : 2026-06-28 10:56:39
* Original cell  : gf180mcu_fd_io__asig_5p0
* Extract cell   : gf180mcu_fd_io__asig_5p0_flat
* Mode           : rcx
* PDK variant    : gf180mcuD
* PDK_ROOT       : /foss/pdks
* Magic rcfile   : /foss/pdks/gf180mcuD/libs.tech/magic/gf180mcuD.magicrc
* Magic version  : 8.3.642
* Input file     : /foss/designs/tempo/gf180mcu_fd_io__asig_5p0.mag
* Input SHA256   : b7950e1f6a5ae4d82e0e5163045f40a82544743de6961f8f8cf58fcffcfc2c4f
* Command        : magic_pex_gf180_v7.py gf180mcu_fd_io__asig_5p0.mag --pdk gf180mcuD --mode rcx --flatten --cthresh 0.1 --extresist-thresh-ohm 0.25 --merge none --no-wrapper --check-junctions --keep-temp --log asig_5p0_rcx_magic.log --live --progress-interval 15
* Options        : flatten, mode=rcx, cthresh=0.1, extresist=250mohm, format=ngspice, merge=none, live
* -----------------------------------------------------------------------------

* NGSPICE file created from gf180mcu_fd_io__asig_5p0_flat.ext - technology: gf180mcuD

*.subckt gf180mcu_fd_io__asig_5p0_flat ASIG5V DVDD DVSS VDD VSS
.SUBCKT gf180mcu_fd_io__asig_5p0 DVDD ASIG5V DVSS VDD VSS
X0 DVDD.t0 DVSS cap_nmos_06v0 c_width=15u c_length=15u
X1 DVDD.t0 DVSS cap_nmos_06v0 c_width=15u c_length=15u
X2 DVDD.t0 DVSS cap_nmos_06v0 c_width=15u c_length=15u
D0 DVSS ASIG5V diode_nd2ps_06v0 pj=0.106m area=0.15n
X3 DVDD.t0 DVSS cap_nmos_06v0 c_width=15u c_length=15u
X4 DVDD.t0 DVSS cap_nmos_06v0 c_width=15u c_length=15u
X5 DVDD.t0 DVSS cap_nmos_06v0 c_width=15u c_length=15u
X6 DVDD.t0 DVSS cap_nmos_06v0 c_width=15u c_length=15u
X7 DVDD.t0 DVSS cap_nmos_06v0 c_width=15u c_length=15u
X8 DVDD.t0 DVSS cap_nmos_06v0 c_width=15u c_length=15u
X9 DVDD.t0 DVSS cap_nmos_06v0 c_width=15u c_length=15u
D1 DVSS ASIG5V diode_nd2ps_06v0 pj=0.106m area=0.15n
D2 ASIG5V DVDD.t0 diode_pd2nw_06v0 pj=0.106m area=0.15n
X10 DVDD.t0 DVSS cap_nmos_06v0 c_width=15u c_length=15u
X11 DVDD.t0 DVSS cap_nmos_06v0 c_width=15u c_length=15u
X12 DVDD.t0 DVSS cap_nmos_06v0 c_width=15u c_length=15u
X13 DVDD.t0 DVSS cap_nmos_06v0 c_width=15u c_length=15u
X14 DVDD.t0 DVSS cap_nmos_06v0 c_width=15u c_length=15u
X15 DVDD.t0 DVSS cap_nmos_06v0 c_width=15u c_length=15u
X16 DVDD.t0 DVSS cap_nmos_06v0 c_width=15u c_length=15u
D3 ASIG5V DVDD.t0 diode_pd2nw_06v0 pj=0.106m area=0.15n
X17 DVDD.t0 DVSS cap_nmos_06v0 c_width=15u c_length=15u
X18 DVDD.t0 DVSS cap_nmos_06v0 c_width=15u c_length=15u
X19 DVDD.t0 DVSS cap_nmos_06v0 c_width=15u c_length=15u
D4 DVSS ASIG5V diode_nd2ps_06v0 pj=0.106m area=0.15n
X20 DVDD.t0 DVSS cap_nmos_06v0 c_width=15u c_length=15u
X21 DVDD.t0 DVSS cap_nmos_06v0 c_width=15u c_length=15u
D5 ASIG5V DVDD.t0 diode_pd2nw_06v0 pj=0.106m area=0.15n
X22 DVDD.t0 DVSS cap_nmos_06v0 c_width=15u c_length=15u
X23 DVDD.t0 DVSS cap_nmos_06v0 c_width=15u c_length=15u
D6 DVSS DVDD.t0 diode_nd2ps_06v0 pj=82u area=40p
X24 DVDD.t0 DVSS cap_nmos_06v0 c_width=15u c_length=15u
X25 DVDD.t0 DVSS cap_nmos_06v0 c_width=15u c_length=15u
D7 DVSS DVDD.t0 diode_nd2ps_06v0 pj=82u area=40p
X26 DVDD.t0 DVSS cap_nmos_06v0 c_width=15u c_length=15u
D8 DVSS ASIG5V diode_nd2ps_06v0 pj=0.106m area=0.15n
X27 DVDD.t0 DVSS cap_nmos_06v0 c_width=15u c_length=15u
X28 DVDD.t0 DVSS cap_nmos_06v0 c_width=15u c_length=15u
D9 DVSS DVDD.t0 diode_nd2ps_06v0 pj=82u area=40p
D10 ASIG5V DVDD.t0 diode_pd2nw_06v0 pj=0.106m area=0.15n
X29 DVDD.t1 DVSS cap_nmos_06v0 c_width=15u c_length=15u
X30 DVDD.t0 DVSS cap_nmos_06v0 c_width=15u c_length=15u
D11 DVSS DVDD.t0 diode_nd2ps_06v0 pj=82u area=40p
X31 DVDD.t0 DVSS cap_nmos_06v0 c_width=15u c_length=15u
X32 DVDD.t0 DVSS cap_nmos_06v0 c_width=15u c_length=15u
X33 DVDD.t0 DVSS cap_nmos_06v0 c_width=15u c_length=15u
X34 DVDD.t0 DVSS cap_nmos_06v0 c_width=15u c_length=15u
X35 DVDD.t0 DVSS cap_nmos_06v0 c_width=15u c_length=15u
R0 DVDD.t1 DVDD.t0 5.03228
R1 DVDD DVDD.t0 0.0005
R2 VSS.n1 DVSS 20126
R3 DVSS VSS.n0 20126
R4 DVSS VSS.n2 17859.7
R5 VSS.n2 DVSS 17859.7
R6 DVSS VSS.n1 6553.98
R7 DVSS VSS.n0 6553.98
R8 VSS.n1 DVSS 5490.26
R9 DVSS VSS.n0 5490.27
R10 VSS.n2 DVSS 496.031
R11 VSS DVSS 0.0005
R12 DVSS DVSS.n21 10867.8
R13 DVSS.n22 DVSS.n35 17859.7
R14 DVSS.n35 DVSS.n21 17859.7
R15 DVSS.n22 DVSS 10867.5
R16 DVSS.n34 DVSS 7.51254
R17 DVSS DVSS.n32 3474.96
R18 DVSS.n17 DVSS.n33 1200.62
R19 DVSS.n34 DVSS.n17 1199.98
R20 DVSS.n17 DVSS 794.593
R21 DVSS DVSS.n1 130.218
R22 DVSS DVSS.n9 46.2718
R23 DVSS.n27 DVSS 130.218
R24 DVSS.n32 DVSS 127.05
R25 DVSS.n33 DVSS 96.9374
R26 DVSS.n3 DVSS 93.6563
R27 DVSS.n5 DVSS 93.6563
R28 DVSS.n4 DVSS 93.6563
R29 DVSS.n7 DVSS 93.6563
R30 DVSS.n6 DVSS 93.6563
R31 DVSS.n8 DVSS 93.6563
R32 DVSS.n28 DVSS 75.5231
R33 DVSS.n30 DVSS 75.5231
R34 DVSS.n29 DVSS 75.5231
R35 DVSS DVSS.n17 57.1732
R36 DVSS.n5 DVSS 14.4308
R37 DVSS DVSS.n4 14.4308
R38 DVSS DVSS.n3 14.4308
R39 DVSS.n3 DVSS 14.4308
R40 DVSS DVSS.n8 14.4308
R41 DVSS DVSS.n7 14.4308
R42 DVSS.n7 DVSS 14.4308
R43 DVSS DVSS.n5 14.4308
R44 DVSS DVSS.n6 14.4308
R45 DVSS DVSS.n6 14.4308
R46 DVSS.n4 DVSS 14.4308
R47 DVSS.n8 DVSS 14.4308
R48 DVSS.n24 VSS 7.99992
R49 VSS DVSS.n24 7.96398
R50 DVSS.n22 DVSS.n17 7.08357
R51 DVSS.n17 DVSS.n21 7.08357
R52 DVSS.n28 DVSS.n1 6.79968
R53 DVSS.n0 DVSS.n9 9.21617
R54 DVSS.n9 DVSS 4.44502
R55 DVSS.n31 DVSS.n29 6.79968
R56 DVSS.n31 DVSS.n30 6.79968
R57 DVSS.n30 DVSS.n2 6.79968
R58 DVSS.n2 DVSS.n28 6.79968
R59 DVSS.n29 DVSS.n27 6.79968
R60 DVSS.n26 DVSS 4.5005
R61 DVSS DVSS.n14 4.5005
R62 DVSS DVSS.n15 4.5005
R63 DVSS DVSS.n12 4.5005
R64 DVSS DVSS.n16 1.88396
R65 DVSS.n10 DVSS 1.49198
R66 DVSS.n18 DVSS 0.638765
R67 DVSS.n18 DVSS 1.93212
R68 DVSS.n19 DVSS 0.638767
R69 DVSS DVSS.n19 1.93212
R70 DVSS DVSS.n18 0.638765
R71 DVSS DVSS.n19 0.638767
R72 DVSS.n10 DVSS 0.651393
R73 DVSS DVSS.n10 0.649183
R74 DVSS.n21 DVSS.n23 5.11977
R75 DVSS.n23 DVSS.n22 5.08442
R76 DVSS.n25 DVSS 2.24011
R77 DVSS DVSS.n11 2.24011
R78 DVSS DVSS.n13 2.24011
R79 DVSS.n16 DVSS.n20 1.77149
R80 DVSS.n20 DVSS 13.0027
R81 DVSS.n30 DVSS 1.35477
R82 DVSS.n4 DVSS 1.35477
R83 DVSS.n7 DVSS 1.35477
R84 DVSS DVSS.n1 0.743357
R85 DVSS.n32 DVSS.n1 0.743357
R86 DVSS DVSS.n0 1.6478
R87 DVSS.n0 DVSS 0.743357
R88 DVSS DVSS.n2 0.743357
R89 DVSS.n32 DVSS.n2 0.743357
R90 DVSS.n27 DVSS 0.743357
R91 DVSS.n32 DVSS.n27 0.743357
R92 DVSS.n31 DVSS 0.743357
R93 DVSS.n32 DVSS.n31 0.743357
R94 DVSS.n25 DVSS.n13 0.0450718
R95 DVSS.n15 DVSS 0.818902
R96 DVSS.n12 DVSS.n14 0.0442838
R97 DVSS.n26 DVSS 0.834007
R98 DVSS.n14 DVSS.n11 0.0227859
R99 DVSS.n15 DVSS.n25 0.0227859
R100 DVSS.n12 DVSS.n13 0.0227859
R101 DVSS.n26 DVSS.n11 0.0227859
R102 DVSS.n24 DVSS.n33 0.0171667
R103 DVSS.n23 DVSS.n34 0.0171667
R104 DVSS.n17 VSS 3.45225
R105 DVSS.n20 DVSS 1.77296
R106 DVSS DVSS.n16 1.76858
R107 DVSS.n35 DVSS 496.205
C0 ASIG5V DVDD 0.62616p
C1 ASIG5V VDD 21.911f
C2 DVDD VDD 48.1675f
C3 VDD VSS 87.1103f
C4 ASIG5V VSS 1.28549p
C5 DVDD VSS 1.97919p
C6 DVDD.t0 VSS 0.33793p
C7 DVDD.t1 VSS 0.33639p
.ends
